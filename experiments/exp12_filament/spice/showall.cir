* list instance outputs
.option scale=1e-6
.temp 27
.include /mnt/e/quantum_cell/data/sky130_models/nfet_mismatch.spice
.include /mnt/e/quantum_cell/experiments/exp12_filament/spice/nfet_01v8_tt_fii.spice
.param fii = 1.0
.param fjun = 1.0
Vd d 0 1.8
Vg g 0 1.2
Vb b 0 0.4
X1 d g 0 b sky130_fd_pr__nfet_01v8 l=0.15 w=1
.control
op
show m.x1.msky130_fd_pr__nfet_01v8 : all
print i(Vd) i(Vb)
quit
.endc
.end
